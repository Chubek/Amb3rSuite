RC divider - transient with zero initial capacitor voltage
V1 in 0 DC 8
R1 in out 1k
R2 out 0 3k
C1 out 0 1u IC=0
.tran 75u 6m UIC
.print tran v(out)
.end
